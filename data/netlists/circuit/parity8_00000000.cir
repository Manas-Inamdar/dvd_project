* example parity8 netlist, inputs 00000000 - corner 0
.options gmin=1e-18 abstol=1e-18 reltol=1e-6 vntol=1e-9
.temp 6.977731632e+01

.model  nmos  nmos  level = 54

+version = 4.0             binunit = 1               paramchk= 1               mobmod  = 0
+capmod  = 2               igcmod  = 1               igbmod  = 1               geomod  = 1
+diomod  = 1               rdsmod  = 0               rbodymod= 1               rgatemod= 1
+permod  = 1               acnqsmod= 0               trnqsmod= 0

+tnom    = 27              toxe    = 1.460495052e-09        toxp    = 1.1e-009        toxm    = 1.4e-009
+dtox    = 3e-010          epsrox  = 3.9             wint    = 5e-009          lint    = 0
+ll      = 0               wl      = 0               lln     = 1               wln     = 1
+lw      = 0               ww      = 0               lwn     = 1               wwn     = 1
+lwl     = 0               wwl     = 0               xpart   = 0               toxref  = 1.4e-009

+vth0    = 6.522761100e-01         k1      = 0.4             k2      = 0               k3      = 0
+k3b     = 0               w0      = 2.5e-006        dvt0    = 1               dvt1    = 2
+dvt2    = 0               dvt0w   = 0               dvt1w   = 0               dvt2w   = 0
+dsub    = 0.1             minv    = 0.05            voffl   = 0               dvtp0   = 1e-011
+dvtp1   = 0.1             lpe0    = 0               lpeb    = 0               xj      = 7.060913494e-09
+ngate   = 1e+023          ndep    = 5.269612571e+18        nsd     = 2e+020          phin    = 0
+cdsc    = 0               cdscb   = 0               cdscd   = 0               cit     = 0
+voff    = -0.1092         nfactor = 1.6             eta0    = 0.0105          etab    = 0
+vfb     = -0.55           u0      = 3.668318663e-02           ua      = 6e-010          ub      = 1.2e-018
+uc      = 0               vsat    = 170000          a0      = 1               ags     = 0
+a1      = 0               a2      = 1               b0      = 0               b1      = 0
+keta    = 0.04            dwg     = 0               dwb     = 0               pclm    = 0.02
+pdiblc1 = 0.001           pdiblc2 = 0.001           pdiblcb = -0.005          drout   = 0.5
+pvag    = 1e-020          delta   = 0.01            pscbe1  = 8.14e+008       pscbe2  = 1e-007
+fprout  = 0.2             pdits   = 0.01            pditsd  = 0.23            pditsl  = 2300000
+rsh     = 5               rdsw    = 180             rsw     = 75              rdw     = 75
+rdswmin = 0               rdwmin  = 0               rswmin  = 0               prwg    = 0
+prwb    = 0               wr      = 1               alpha0  = 0.074           alpha1  = 0.005
+beta0   = 30              agidl   = 0.0002          bgidl   = 2.1e+009        cgidl   = 0.0002
+egidl   = 0.8             aigbacc = 0.012           bigbacc = 0.0028          cigbacc = 0.002
+nigbacc = 1               aigbinv = 0.014           bigbinv = 0.004           cigbinv = 0.004
+eigbinv = 1.1             nigbinv = 3               aigc    = 0.015211        bigc    = 0.0027432
+cigc    = 0.002           aigsd   = 0.015211        bigsd   = 0.0027432       cigsd   = 0.002
+nigc    = 1               poxedge = 1               pigcd   = 1               ntox    = 1
+xrcrg1  = 12              xrcrg2  = 5

+cgso    = 6.5e-011        cgdo    = 6.5e-011        cgbo    = 2.56e-011       cgdl    = 2.653e-010
+cgsl    = 2.653e-010      ckappas = 0.03            ckappad = 0.03            acde    = 1
+moin    = 15              noff    = 0.9             voffcv  = 0.02

+kt1     = -0.11           kt1l    = 0               kt2     = 0.022           ute     = -1.5
+ua1     = 4.31e-009       ub1     = 7.61e-018       uc1     = -5.6e-011       prt     = 0
+at      = 33000

+fnoimod = 1               tnoimod = 0

+jss     = 0.0001          jsws    = 1e-011          jswgs   = 1e-010          njs     = 1
+ijthsfwd= 0.01            ijthsrev= 0.001           bvs     = 10              xjbvs   = 1
+jsd     = 0.0001          jswd    = 1e-011          jswgd   = 1e-010          njd     = 1
+ijthdfwd= 0.01            ijthdrev= 0.001           bvd     = 10              xjbvd   = 1
+pbs     = 1               cjs     = 0.0005          mjs     = 0.5             pbsws   = 1
+cjsws   = 5e-010          mjsws   = 0.33            pbswgs  = 1               cjswgs  = 3e-010
+mjswgs  = 0.33            pbd     = 1               cjd     = 0.0005          mjd     = 0.5
+pbswd   = 1               cjswd   = 5e-010          mjswd   = 0.33            pbswgd  = 1
+cjswgd  = 5e-010          mjswgd  = 0.33            tpb     = 0.005           tcj     = 0.001
+tpbsw   = 0.005           tcjsw   = 0.001           tpbswg  = 0.005           tcjswg  = 0.001
+xtis    = 3               xtid    = 3

+dmcg    = 0               dmci    = 0               dmdg    = 0               dmcgt   = 0
+dwj     = 0               xgw     = 0               xgl     = 0

+rshg    = 0.4             gbmin   = 1e-010          rbpb    = 5               rbpd    = 15
+rbps    = 15              rbdb    = 15              rbsb    = 15              ngcon   = 1

.model  pmos  pmos  level = 54

+version = 4.0             binunit = 1               paramchk= 1               mobmod  = 0
+capmod  = 2               igcmod  = 1               igbmod  = 1               geomod  = 1
+diomod  = 1               rdsmod  = 0               rbodymod= 1               rgatemod= 1
+permod  = 1               acnqsmod= 0               trnqsmod= 0

+tnom    = 27              toxe    = 1.442272577e-09        toxp    = 1.08e-009       toxm    = 1.42e-009
+dtox    = 3.2e-010        epsrox  = 3.9             wint    = 5e-009          lint    = 0
+ll      = 0               wl      = 0               lln     = 1               wln     = 1
+lw      = 0               ww      = 0               lwn     = 1               wwn     = 1
+lwl     = 0               wwl     = 0               xpart   = 0               toxref  = 1.42e-009

+vth0    = -6.478417648e-01        k1      = 0.4             k2      = -0.01           k3      = 0
+k3b     = 0               w0      = 2.5e-006        dvt0    = 1               dvt1    = 2
+dvt2    = -0.032          dvt0w   = 0               dvt1w   = 0               dvt2w   = 0
+dsub    = 0.1             minv    = 0.05            voffl   = 0               dvtp0   = 1e-011
+dvtp1   = 0.05            lpe0    = 0               lpeb    = 0               xj      = 7.046310034e-09
+ngate   = 1e+023          ndep    = 4.443055037e+18        nsd     = 2e+020          phin    = 0
+cdsc    = 0               cdscb   = 0               cdscd   = 0               cit     = 0
+voff    = -0.09           nfactor = 1.8             eta0    = 0.0105          etab    = 0
+vfb     = 0.55            u0      = 1.035727841e-02           ua      = 2e-009          ub      = 5e-019
+uc      = 0               vsat    = 170000          a0      = 1               ags     = 1e-020
+a1      = 0               a2      = 1               b0      = 0               b1      = 0
+keta    = -0.047          dwg     = 0               dwb     = 0               pclm    = 0.12
+pdiblc1 = 0.001           pdiblc2 = 0.001           pdiblcb = 3.4e-008        drout   = 0.56
+pvag    = 1e-020          delta   = 0.01            pscbe1  = 8.14e+008       pscbe2  = 9.58e-007
+fprout  = 0.2             pdits   = 0.08            pditsd  = 0.23            pditsl  = 2300000
+rsh     = 5               rdsw    = 230             rsw     = 72.5            rdw     = 72.5
+rdswmin = 0               rdwmin  = 0               rswmin  = 0               prwg    = 0
+prwb    = 0               wr      = 1               alpha0  = 0.074           alpha1  = 0.005
+beta0   = 30              agidl   = 0.0002          bgidl   = 2.1e+009        cgidl   = 0.0002
+egidl   = 0.8             aigbacc = 0.012           bigbacc = 0.0028          cigbacc = 0.002
+nigbacc = 1               aigbinv = 0.014           bigbinv = 0.004           cigbinv = 0.004
+eigbinv = 1.1             nigbinv = 3               aigc    = 0.0097          bigc    = 0.00125
+cigc    = 0.0008          aigsd   = 0.0097          bigsd   = 0.00125         cigsd   = 0.0008
+nigc    = 1               poxedge = 1               pigcd   = 1               ntox    = 1
+xrcrg1  = 12              xrcrg2  = 5

+cgso    = 6.5e-011        cgdo    = 6.5e-011        cgbo    = 2.56e-011       cgdl    = 2.653e-010
+cgsl    = 2.653e-010      ckappas = 0.03            ckappad = 0.03            acde    = 1
+moin    = 15              noff    = 0.9             voffcv  = 0.02

+kt1     = -0.11           kt1l    = 0               kt2     = 0.022           ute     = -1.5
+ua1     = 4.31e-009       ub1     = 7.61e-018       uc1     = -5.6e-011       prt     = 0
+at      = 33000

+fnoimod = 1               tnoimod = 0

+jss     = 0.0001          jsws    = 1e-011          jswgs   = 1e-010          njs     = 1
+ijthsfwd= 0.01            ijthsrev= 0.001           bvs     = 10              xjbvs   = 1
+jsd     = 0.0001          jswd    = 1e-011          jswgd   = 1e-010          njd     = 1
+ijthdfwd= 0.01            ijthdrev= 0.001           bvd     = 10              xjbvd   = 1
+pbs     = 1               cjs     = 0.0005          mjs     = 0.5             pbsws   = 1
+cjsws   = 5e-010          mjsws   = 0.33            pbswgs  = 1               cjswgs  = 3e-010
+mjswgs  = 0.33            pbd     = 1               cjd     = 0.0005          mjd     = 0.5
+pbswd   = 1               cjswd   = 5e-010          mjswd   = 0.33            pbswgd  = 1
+cjswgd  = 5e-010          mjswgd  = 0.33            tpb     = 0.005           tcj     = 0.001
+tpbsw   = 0.005           tcjsw   = 0.001           tpbswg  = 0.005           tcjswg  = 0.001
+xtis    = 3               xtid    = 3

+dmcg    = 0               dmci    = 0               dmdg    = 0               dmcgt   = 0
+dwj     = 0               xgw     = 0               xgl     = 0

+rshg    = 0.4             gbmin   = 1e-010          rbpb    = 5               rbpd    = 15
+rbps    = 15              rbdb    = 15              rbsb    = 15              ngcon   = 1

* --- 28 NAND2 gates (4 transistors each): drain gate source body ---
M_x1_0_g1_Mp1 x1_0_n1 i0 vdd vdd pmos W=4.400000000e-08 L=2.200000000e-08 AD=1.936000000e-15 AS=1.936000000e-15
M_x1_0_g1_Mp2 x1_0_n1 i1 vdd vdd pmos W=4.400000000e-08 L=2.200000000e-08 AD=1.936000000e-15 AS=1.936000000e-15
M_x1_0_g1_Mn1 x1_0_n1 i0 x1_0_g1_x vss nmos W=4.400000000e-08 L=2.200000000e-08 AD=1.936000000e-15 AS=1.936000000e-15
M_x1_0_g1_Mn2 x1_0_g1_x i1 vss vss nmos W=4.400000000e-08 L=2.200000000e-08 AD=1.936000000e-15 AS=1.936000000e-15
M_x1_0_g2_Mp1 x1_0_n2 i0 vdd vdd pmos W=4.400000000e-08 L=2.200000000e-08 AD=1.936000000e-15 AS=1.936000000e-15
M_x1_0_g2_Mp2 x1_0_n2 x1_0_n1 vdd vdd pmos W=4.400000000e-08 L=2.200000000e-08 AD=1.936000000e-15 AS=1.936000000e-15
M_x1_0_g2_Mn1 x1_0_n2 i0 x1_0_g2_x vss nmos W=4.400000000e-08 L=2.200000000e-08 AD=1.936000000e-15 AS=1.936000000e-15
M_x1_0_g2_Mn2 x1_0_g2_x x1_0_n1 vss vss nmos W=4.400000000e-08 L=2.200000000e-08 AD=1.936000000e-15 AS=1.936000000e-15
M_x1_0_g3_Mp1 x1_0_n3 i1 vdd vdd pmos W=4.400000000e-08 L=2.200000000e-08 AD=1.936000000e-15 AS=1.936000000e-15
M_x1_0_g3_Mp2 x1_0_n3 x1_0_n1 vdd vdd pmos W=4.400000000e-08 L=2.200000000e-08 AD=1.936000000e-15 AS=1.936000000e-15
M_x1_0_g3_Mn1 x1_0_n3 i1 x1_0_g3_x vss nmos W=4.400000000e-08 L=2.200000000e-08 AD=1.936000000e-15 AS=1.936000000e-15
M_x1_0_g3_Mn2 x1_0_g3_x x1_0_n1 vss vss nmos W=4.400000000e-08 L=2.200000000e-08 AD=1.936000000e-15 AS=1.936000000e-15
M_x1_0_g4_Mp1 s1_0 x1_0_n2 vdd vdd pmos W=4.400000000e-08 L=2.200000000e-08 AD=1.936000000e-15 AS=1.936000000e-15
M_x1_0_g4_Mp2 s1_0 x1_0_n3 vdd vdd pmos W=4.400000000e-08 L=2.200000000e-08 AD=1.936000000e-15 AS=1.936000000e-15
M_x1_0_g4_Mn1 s1_0 x1_0_n2 x1_0_g4_x vss nmos W=4.400000000e-08 L=2.200000000e-08 AD=1.936000000e-15 AS=1.936000000e-15
M_x1_0_g4_Mn2 x1_0_g4_x x1_0_n3 vss vss nmos W=4.400000000e-08 L=2.200000000e-08 AD=1.936000000e-15 AS=1.936000000e-15
M_x1_1_g1_Mp1 x1_1_n1 i2 vdd vdd pmos W=4.400000000e-08 L=2.200000000e-08 AD=1.936000000e-15 AS=1.936000000e-15
M_x1_1_g1_Mp2 x1_1_n1 i3 vdd vdd pmos W=4.400000000e-08 L=2.200000000e-08 AD=1.936000000e-15 AS=1.936000000e-15
M_x1_1_g1_Mn1 x1_1_n1 i2 x1_1_g1_x vss nmos W=4.400000000e-08 L=2.200000000e-08 AD=1.936000000e-15 AS=1.936000000e-15
M_x1_1_g1_Mn2 x1_1_g1_x i3 vss vss nmos W=4.400000000e-08 L=2.200000000e-08 AD=1.936000000e-15 AS=1.936000000e-15
M_x1_1_g2_Mp1 x1_1_n2 i2 vdd vdd pmos W=4.400000000e-08 L=2.200000000e-08 AD=1.936000000e-15 AS=1.936000000e-15
M_x1_1_g2_Mp2 x1_1_n2 x1_1_n1 vdd vdd pmos W=4.400000000e-08 L=2.200000000e-08 AD=1.936000000e-15 AS=1.936000000e-15
M_x1_1_g2_Mn1 x1_1_n2 i2 x1_1_g2_x vss nmos W=4.400000000e-08 L=2.200000000e-08 AD=1.936000000e-15 AS=1.936000000e-15
M_x1_1_g2_Mn2 x1_1_g2_x x1_1_n1 vss vss nmos W=4.400000000e-08 L=2.200000000e-08 AD=1.936000000e-15 AS=1.936000000e-15
M_x1_1_g3_Mp1 x1_1_n3 i3 vdd vdd pmos W=4.400000000e-08 L=2.200000000e-08 AD=1.936000000e-15 AS=1.936000000e-15
M_x1_1_g3_Mp2 x1_1_n3 x1_1_n1 vdd vdd pmos W=4.400000000e-08 L=2.200000000e-08 AD=1.936000000e-15 AS=1.936000000e-15
M_x1_1_g3_Mn1 x1_1_n3 i3 x1_1_g3_x vss nmos W=4.400000000e-08 L=2.200000000e-08 AD=1.936000000e-15 AS=1.936000000e-15
M_x1_1_g3_Mn2 x1_1_g3_x x1_1_n1 vss vss nmos W=4.400000000e-08 L=2.200000000e-08 AD=1.936000000e-15 AS=1.936000000e-15
M_x1_1_g4_Mp1 s1_1 x1_1_n2 vdd vdd pmos W=4.400000000e-08 L=2.200000000e-08 AD=1.936000000e-15 AS=1.936000000e-15
M_x1_1_g4_Mp2 s1_1 x1_1_n3 vdd vdd pmos W=4.400000000e-08 L=2.200000000e-08 AD=1.936000000e-15 AS=1.936000000e-15
M_x1_1_g4_Mn1 s1_1 x1_1_n2 x1_1_g4_x vss nmos W=4.400000000e-08 L=2.200000000e-08 AD=1.936000000e-15 AS=1.936000000e-15
M_x1_1_g4_Mn2 x1_1_g4_x x1_1_n3 vss vss nmos W=4.400000000e-08 L=2.200000000e-08 AD=1.936000000e-15 AS=1.936000000e-15
M_x1_2_g1_Mp1 x1_2_n1 i4 vdd vdd pmos W=4.400000000e-08 L=2.200000000e-08 AD=1.936000000e-15 AS=1.936000000e-15
M_x1_2_g1_Mp2 x1_2_n1 i5 vdd vdd pmos W=4.400000000e-08 L=2.200000000e-08 AD=1.936000000e-15 AS=1.936000000e-15
M_x1_2_g1_Mn1 x1_2_n1 i4 x1_2_g1_x vss nmos W=4.400000000e-08 L=2.200000000e-08 AD=1.936000000e-15 AS=1.936000000e-15
M_x1_2_g1_Mn2 x1_2_g1_x i5 vss vss nmos W=4.400000000e-08 L=2.200000000e-08 AD=1.936000000e-15 AS=1.936000000e-15
M_x1_2_g2_Mp1 x1_2_n2 i4 vdd vdd pmos W=4.400000000e-08 L=2.200000000e-08 AD=1.936000000e-15 AS=1.936000000e-15
M_x1_2_g2_Mp2 x1_2_n2 x1_2_n1 vdd vdd pmos W=4.400000000e-08 L=2.200000000e-08 AD=1.936000000e-15 AS=1.936000000e-15
M_x1_2_g2_Mn1 x1_2_n2 i4 x1_2_g2_x vss nmos W=4.400000000e-08 L=2.200000000e-08 AD=1.936000000e-15 AS=1.936000000e-15
M_x1_2_g2_Mn2 x1_2_g2_x x1_2_n1 vss vss nmos W=4.400000000e-08 L=2.200000000e-08 AD=1.936000000e-15 AS=1.936000000e-15
M_x1_2_g3_Mp1 x1_2_n3 i5 vdd vdd pmos W=4.400000000e-08 L=2.200000000e-08 AD=1.936000000e-15 AS=1.936000000e-15
M_x1_2_g3_Mp2 x1_2_n3 x1_2_n1 vdd vdd pmos W=4.400000000e-08 L=2.200000000e-08 AD=1.936000000e-15 AS=1.936000000e-15
M_x1_2_g3_Mn1 x1_2_n3 i5 x1_2_g3_x vss nmos W=4.400000000e-08 L=2.200000000e-08 AD=1.936000000e-15 AS=1.936000000e-15
M_x1_2_g3_Mn2 x1_2_g3_x x1_2_n1 vss vss nmos W=4.400000000e-08 L=2.200000000e-08 AD=1.936000000e-15 AS=1.936000000e-15
M_x1_2_g4_Mp1 s1_2 x1_2_n2 vdd vdd pmos W=4.400000000e-08 L=2.200000000e-08 AD=1.936000000e-15 AS=1.936000000e-15
M_x1_2_g4_Mp2 s1_2 x1_2_n3 vdd vdd pmos W=4.400000000e-08 L=2.200000000e-08 AD=1.936000000e-15 AS=1.936000000e-15
M_x1_2_g4_Mn1 s1_2 x1_2_n2 x1_2_g4_x vss nmos W=4.400000000e-08 L=2.200000000e-08 AD=1.936000000e-15 AS=1.936000000e-15
M_x1_2_g4_Mn2 x1_2_g4_x x1_2_n3 vss vss nmos W=4.400000000e-08 L=2.200000000e-08 AD=1.936000000e-15 AS=1.936000000e-15
M_x1_3_g1_Mp1 x1_3_n1 i6 vdd vdd pmos W=4.400000000e-08 L=2.200000000e-08 AD=1.936000000e-15 AS=1.936000000e-15
M_x1_3_g1_Mp2 x1_3_n1 i7 vdd vdd pmos W=4.400000000e-08 L=2.200000000e-08 AD=1.936000000e-15 AS=1.936000000e-15
M_x1_3_g1_Mn1 x1_3_n1 i6 x1_3_g1_x vss nmos W=4.400000000e-08 L=2.200000000e-08 AD=1.936000000e-15 AS=1.936000000e-15
M_x1_3_g1_Mn2 x1_3_g1_x i7 vss vss nmos W=4.400000000e-08 L=2.200000000e-08 AD=1.936000000e-15 AS=1.936000000e-15
M_x1_3_g2_Mp1 x1_3_n2 i6 vdd vdd pmos W=4.400000000e-08 L=2.200000000e-08 AD=1.936000000e-15 AS=1.936000000e-15
M_x1_3_g2_Mp2 x1_3_n2 x1_3_n1 vdd vdd pmos W=4.400000000e-08 L=2.200000000e-08 AD=1.936000000e-15 AS=1.936000000e-15
M_x1_3_g2_Mn1 x1_3_n2 i6 x1_3_g2_x vss nmos W=4.400000000e-08 L=2.200000000e-08 AD=1.936000000e-15 AS=1.936000000e-15
M_x1_3_g2_Mn2 x1_3_g2_x x1_3_n1 vss vss nmos W=4.400000000e-08 L=2.200000000e-08 AD=1.936000000e-15 AS=1.936000000e-15
M_x1_3_g3_Mp1 x1_3_n3 i7 vdd vdd pmos W=4.400000000e-08 L=2.200000000e-08 AD=1.936000000e-15 AS=1.936000000e-15
M_x1_3_g3_Mp2 x1_3_n3 x1_3_n1 vdd vdd pmos W=4.400000000e-08 L=2.200000000e-08 AD=1.936000000e-15 AS=1.936000000e-15
M_x1_3_g3_Mn1 x1_3_n3 i7 x1_3_g3_x vss nmos W=4.400000000e-08 L=2.200000000e-08 AD=1.936000000e-15 AS=1.936000000e-15
M_x1_3_g3_Mn2 x1_3_g3_x x1_3_n1 vss vss nmos W=4.400000000e-08 L=2.200000000e-08 AD=1.936000000e-15 AS=1.936000000e-15
M_x1_3_g4_Mp1 s1_3 x1_3_n2 vdd vdd pmos W=4.400000000e-08 L=2.200000000e-08 AD=1.936000000e-15 AS=1.936000000e-15
M_x1_3_g4_Mp2 s1_3 x1_3_n3 vdd vdd pmos W=4.400000000e-08 L=2.200000000e-08 AD=1.936000000e-15 AS=1.936000000e-15
M_x1_3_g4_Mn1 s1_3 x1_3_n2 x1_3_g4_x vss nmos W=4.400000000e-08 L=2.200000000e-08 AD=1.936000000e-15 AS=1.936000000e-15
M_x1_3_g4_Mn2 x1_3_g4_x x1_3_n3 vss vss nmos W=4.400000000e-08 L=2.200000000e-08 AD=1.936000000e-15 AS=1.936000000e-15
M_x2_0_g1_Mp1 x2_0_n1 s1_0 vdd vdd pmos W=4.400000000e-08 L=2.200000000e-08 AD=1.936000000e-15 AS=1.936000000e-15
M_x2_0_g1_Mp2 x2_0_n1 s1_1 vdd vdd pmos W=4.400000000e-08 L=2.200000000e-08 AD=1.936000000e-15 AS=1.936000000e-15
M_x2_0_g1_Mn1 x2_0_n1 s1_0 x2_0_g1_x vss nmos W=4.400000000e-08 L=2.200000000e-08 AD=1.936000000e-15 AS=1.936000000e-15
M_x2_0_g1_Mn2 x2_0_g1_x s1_1 vss vss nmos W=4.400000000e-08 L=2.200000000e-08 AD=1.936000000e-15 AS=1.936000000e-15
M_x2_0_g2_Mp1 x2_0_n2 s1_0 vdd vdd pmos W=4.400000000e-08 L=2.200000000e-08 AD=1.936000000e-15 AS=1.936000000e-15
M_x2_0_g2_Mp2 x2_0_n2 x2_0_n1 vdd vdd pmos W=4.400000000e-08 L=2.200000000e-08 AD=1.936000000e-15 AS=1.936000000e-15
M_x2_0_g2_Mn1 x2_0_n2 s1_0 x2_0_g2_x vss nmos W=4.400000000e-08 L=2.200000000e-08 AD=1.936000000e-15 AS=1.936000000e-15
M_x2_0_g2_Mn2 x2_0_g2_x x2_0_n1 vss vss nmos W=4.400000000e-08 L=2.200000000e-08 AD=1.936000000e-15 AS=1.936000000e-15
M_x2_0_g3_Mp1 x2_0_n3 s1_1 vdd vdd pmos W=4.400000000e-08 L=2.200000000e-08 AD=1.936000000e-15 AS=1.936000000e-15
M_x2_0_g3_Mp2 x2_0_n3 x2_0_n1 vdd vdd pmos W=4.400000000e-08 L=2.200000000e-08 AD=1.936000000e-15 AS=1.936000000e-15
M_x2_0_g3_Mn1 x2_0_n3 s1_1 x2_0_g3_x vss nmos W=4.400000000e-08 L=2.200000000e-08 AD=1.936000000e-15 AS=1.936000000e-15
M_x2_0_g3_Mn2 x2_0_g3_x x2_0_n1 vss vss nmos W=4.400000000e-08 L=2.200000000e-08 AD=1.936000000e-15 AS=1.936000000e-15
M_x2_0_g4_Mp1 s2_0 x2_0_n2 vdd vdd pmos W=4.400000000e-08 L=2.200000000e-08 AD=1.936000000e-15 AS=1.936000000e-15
M_x2_0_g4_Mp2 s2_0 x2_0_n3 vdd vdd pmos W=4.400000000e-08 L=2.200000000e-08 AD=1.936000000e-15 AS=1.936000000e-15
M_x2_0_g4_Mn1 s2_0 x2_0_n2 x2_0_g4_x vss nmos W=4.400000000e-08 L=2.200000000e-08 AD=1.936000000e-15 AS=1.936000000e-15
M_x2_0_g4_Mn2 x2_0_g4_x x2_0_n3 vss vss nmos W=4.400000000e-08 L=2.200000000e-08 AD=1.936000000e-15 AS=1.936000000e-15
M_x2_1_g1_Mp1 x2_1_n1 s1_2 vdd vdd pmos W=4.400000000e-08 L=2.200000000e-08 AD=1.936000000e-15 AS=1.936000000e-15
M_x2_1_g1_Mp2 x2_1_n1 s1_3 vdd vdd pmos W=4.400000000e-08 L=2.200000000e-08 AD=1.936000000e-15 AS=1.936000000e-15
M_x2_1_g1_Mn1 x2_1_n1 s1_2 x2_1_g1_x vss nmos W=4.400000000e-08 L=2.200000000e-08 AD=1.936000000e-15 AS=1.936000000e-15
M_x2_1_g1_Mn2 x2_1_g1_x s1_3 vss vss nmos W=4.400000000e-08 L=2.200000000e-08 AD=1.936000000e-15 AS=1.936000000e-15
M_x2_1_g2_Mp1 x2_1_n2 s1_2 vdd vdd pmos W=4.400000000e-08 L=2.200000000e-08 AD=1.936000000e-15 AS=1.936000000e-15
M_x2_1_g2_Mp2 x2_1_n2 x2_1_n1 vdd vdd pmos W=4.400000000e-08 L=2.200000000e-08 AD=1.936000000e-15 AS=1.936000000e-15
M_x2_1_g2_Mn1 x2_1_n2 s1_2 x2_1_g2_x vss nmos W=4.400000000e-08 L=2.200000000e-08 AD=1.936000000e-15 AS=1.936000000e-15
M_x2_1_g2_Mn2 x2_1_g2_x x2_1_n1 vss vss nmos W=4.400000000e-08 L=2.200000000e-08 AD=1.936000000e-15 AS=1.936000000e-15
M_x2_1_g3_Mp1 x2_1_n3 s1_3 vdd vdd pmos W=4.400000000e-08 L=2.200000000e-08 AD=1.936000000e-15 AS=1.936000000e-15
M_x2_1_g3_Mp2 x2_1_n3 x2_1_n1 vdd vdd pmos W=4.400000000e-08 L=2.200000000e-08 AD=1.936000000e-15 AS=1.936000000e-15
M_x2_1_g3_Mn1 x2_1_n3 s1_3 x2_1_g3_x vss nmos W=4.400000000e-08 L=2.200000000e-08 AD=1.936000000e-15 AS=1.936000000e-15
M_x2_1_g3_Mn2 x2_1_g3_x x2_1_n1 vss vss nmos W=4.400000000e-08 L=2.200000000e-08 AD=1.936000000e-15 AS=1.936000000e-15
M_x2_1_g4_Mp1 s2_1 x2_1_n2 vdd vdd pmos W=4.400000000e-08 L=2.200000000e-08 AD=1.936000000e-15 AS=1.936000000e-15
M_x2_1_g4_Mp2 s2_1 x2_1_n3 vdd vdd pmos W=4.400000000e-08 L=2.200000000e-08 AD=1.936000000e-15 AS=1.936000000e-15
M_x2_1_g4_Mn1 s2_1 x2_1_n2 x2_1_g4_x vss nmos W=4.400000000e-08 L=2.200000000e-08 AD=1.936000000e-15 AS=1.936000000e-15
M_x2_1_g4_Mn2 x2_1_g4_x x2_1_n3 vss vss nmos W=4.400000000e-08 L=2.200000000e-08 AD=1.936000000e-15 AS=1.936000000e-15
M_x3_0_g1_Mp1 x3_0_n1 s2_0 vdd vdd pmos W=4.400000000e-08 L=2.200000000e-08 AD=1.936000000e-15 AS=1.936000000e-15
M_x3_0_g1_Mp2 x3_0_n1 s2_1 vdd vdd pmos W=4.400000000e-08 L=2.200000000e-08 AD=1.936000000e-15 AS=1.936000000e-15
M_x3_0_g1_Mn1 x3_0_n1 s2_0 x3_0_g1_x vss nmos W=4.400000000e-08 L=2.200000000e-08 AD=1.936000000e-15 AS=1.936000000e-15
M_x3_0_g1_Mn2 x3_0_g1_x s2_1 vss vss nmos W=4.400000000e-08 L=2.200000000e-08 AD=1.936000000e-15 AS=1.936000000e-15
M_x3_0_g2_Mp1 x3_0_n2 s2_0 vdd vdd pmos W=4.400000000e-08 L=2.200000000e-08 AD=1.936000000e-15 AS=1.936000000e-15
M_x3_0_g2_Mp2 x3_0_n2 x3_0_n1 vdd vdd pmos W=4.400000000e-08 L=2.200000000e-08 AD=1.936000000e-15 AS=1.936000000e-15
M_x3_0_g2_Mn1 x3_0_n2 s2_0 x3_0_g2_x vss nmos W=4.400000000e-08 L=2.200000000e-08 AD=1.936000000e-15 AS=1.936000000e-15
M_x3_0_g2_Mn2 x3_0_g2_x x3_0_n1 vss vss nmos W=4.400000000e-08 L=2.200000000e-08 AD=1.936000000e-15 AS=1.936000000e-15
M_x3_0_g3_Mp1 x3_0_n3 s2_1 vdd vdd pmos W=4.400000000e-08 L=2.200000000e-08 AD=1.936000000e-15 AS=1.936000000e-15
M_x3_0_g3_Mp2 x3_0_n3 x3_0_n1 vdd vdd pmos W=4.400000000e-08 L=2.200000000e-08 AD=1.936000000e-15 AS=1.936000000e-15
M_x3_0_g3_Mn1 x3_0_n3 s2_1 x3_0_g3_x vss nmos W=4.400000000e-08 L=2.200000000e-08 AD=1.936000000e-15 AS=1.936000000e-15
M_x3_0_g3_Mn2 x3_0_g3_x x3_0_n1 vss vss nmos W=4.400000000e-08 L=2.200000000e-08 AD=1.936000000e-15 AS=1.936000000e-15
M_x3_0_g4_Mp1 out x3_0_n2 vdd vdd pmos W=4.400000000e-08 L=2.200000000e-08 AD=1.936000000e-15 AS=1.936000000e-15
M_x3_0_g4_Mp2 out x3_0_n3 vdd vdd pmos W=4.400000000e-08 L=2.200000000e-08 AD=1.936000000e-15 AS=1.936000000e-15
M_x3_0_g4_Mn1 out x3_0_n2 x3_0_g4_x vss nmos W=4.400000000e-08 L=2.200000000e-08 AD=1.936000000e-15 AS=1.936000000e-15
M_x3_0_g4_Mn2 x3_0_g4_x x3_0_n3 vss vss nmos W=4.400000000e-08 L=2.200000000e-08 AD=1.936000000e-15 AS=1.936000000e-15
* --- sources: supply, ground-rail current probe, primary inputs at exactly 0 or VDD ---
Vdd vdd 0 dc 9.777801461e-01
Vgnd vss 0 dc 0
Vi0 i0 0 dc 0.000000000e+00
Vi1 i1 0 dc 0.000000000e+00
Vi2 i2 0 dc 0.000000000e+00
Vi3 i3 0 dc 0.000000000e+00
Vi4 i4 0 dc 0.000000000e+00
Vi5 i5 0 dc 0.000000000e+00
Vi6 i6 0 dc 0.000000000e+00
Vi7 i7 0 dc 0.000000000e+00
* --- solver start values only (do not constrain the result) ---
.nodeset v(x1_0_n1)=0.977780 v(x1_0_n2)=0.977780 v(x1_0_n3)=0.977780 v(s1_0)=0.000000 v(x1_1_n1)=0.977780 v(x1_1_n2)=0.977780 v(x1_1_n3)=0.977780 v(s1_1)=0.000000 v(x1_2_n1)=0.977780 v(x1_2_n2)=0.977780 v(x1_2_n3)=0.977780 v(s1_2)=0.000000 v(x1_3_n1)=0.977780 v(x1_3_n2)=0.977780 v(x1_3_n3)=0.977780 v(s1_3)=0.000000 v(x2_0_n1)=0.977780 v(x2_0_n2)=0.977780 v(x2_0_n3)=0.977780 v(s2_0)=0.000000 v(x2_1_n1)=0.977780 v(x2_1_n2)=0.977780 v(x2_1_n3)=0.977780 v(s2_1)=0.000000 v(x3_0_n1)=0.977780 v(x3_0_n2)=0.977780 v(x3_0_n3)=0.977780 v(out)=0.000000 v(x1_0_g1_x)=0.050000 v(x1_0_g2_x)=0.050000 v(x1_0_g3_x)=0.050000 v(x1_0_g4_x)=0.050000 v(x1_1_g1_x)=0.050000 v(x1_1_g2_x)=0.050000 v(x1_1_g3_x)=0.050000 v(x1_1_g4_x)=0.050000 v(x1_2_g1_x)=0.050000 v(x1_2_g2_x)=0.050000 v(x1_2_g3_x)=0.050000 v(x1_2_g4_x)=0.050000 v(x1_3_g1_x)=0.050000 v(x1_3_g2_x)=0.050000 v(x1_3_g3_x)=0.050000 v(x1_3_g4_x)=0.050000 v(x2_0_g1_x)=0.050000 v(x2_0_g2_x)=0.050000 v(x2_0_g3_x)=0.050000 v(x2_0_g4_x)=0.050000 v(x2_1_g1_x)=0.050000 v(x2_1_g2_x)=0.050000 v(x2_1_g3_x)=0.050000 v(x2_1_g4_x)=0.050000 v(x3_0_g1_x)=0.050000 v(x3_0_g2_x)=0.050000 v(x3_0_g3_x)=0.050000 v(x3_0_g4_x)=0.050000

.control
set numdgt=12
op
print v(out) i(Vdd) i(Vgnd) i(Vi0) i(Vi1) i(Vi2) i(Vi3) i(Vi4) i(Vi5) i(Vi6) i(Vi7)
.endc
.end
